// Design: Design/flip_flop_simulate
simulator lang=spectre
global 0 vdd!
include "/home/ugrads/r/rohitbarichello/cadence/models/spectre/tsmc20N.m"
include "/home/ugrads/r/rohitbarichello/cadence/models/spectre/tsmc20P.m"

// Design/flip_flop/schematic
subckt flip_flop CLK D GND Q VDD _CLK
    P17 (net39 net38 VDD VDD) tsmc20P w=700n l=200n m=1 region=sat
    P16 (net25 CLK net39 VDD) tsmc20P w=700n l=200n m=1 region=sat
    P15 (net38 net25 VDD VDD) tsmc20P w=700n l=200n m=1 region=sat
    P14 (Q net38 VDD VDD) tsmc20P w=700n l=200n m=1 region=sat
    P13 (net25 _CLK net051 VDD) tsmc20P w=700n l=200n m=1 region=sat
    P12 (net051 net13 VDD VDD) tsmc20P w=700n l=200n m=1 region=sat
    P11 (net19 net051 VDD VDD) tsmc20P w=700n l=200n m=1 region=sat
    P10 (net19 _CLK net13 VDD) tsmc20P w=700n l=200n m=1 region=sat
    P1 (net11 CLK net13 VDD) tsmc20P w=700n l=200n m=1 region=sat
    P0 (net11 D VDD VDD) tsmc20P w=700n l=200n m=1 region=sat
    N17 (GND net38 net39 GND) tsmc20N w=300n l=200n m=1 region=sat
    N16 (net25 _CLK net39 GND) tsmc20N w=300n l=200n m=1 region=sat
    N15 (net38 net25 GND GND) tsmc20N w=300n l=200n m=1 region=sat
    N14 (Q net38 GND GND) tsmc20N w=300n l=200n m=1 region=sat
    N1 (net11 _CLK net13 GND) tsmc20N w=300n l=200n m=1 region=sat
    N0 (net11 D GND GND) tsmc20N w=300n l=200n m=1 region=sat
    N13 (net25 CLK net051 GND) tsmc20N w=300n l=200n m=1 region=sat
    N12 (net051 net13 GND GND) tsmc20N w=300n l=200n m=1 region=sat
    N11 (GND net051 net19 GND) tsmc20N w=300n l=200n m=1 region=sat
    N10 (net19 CLK net13 GND) tsmc20N w=300n l=200n m=1 region=sat
ends flip_flop

// Design/flip_flop_simulate/schematic
I0 (CLK D 0 Q vdd! _CLK) flip_flop
V0 (vdd! 0) vsource type=dc dc=1.8
V3 (_CLK 0) vsource type=pulse dc=1.8 val0=0 val1=1.8 period=12n delay=3n rise=100p fall=100p width=5n
V2 (D 0) vsource type=pulse dc=1.8 val0=0 val1=1.8 period=12n delay=3n rise=100p fall=100p width=5n
V1 (CLK 0) vsource type=pulse dc=1.8 val0=0 val1=1.8 period=12n delay=3n rise=100p fall=100p width=5n
C0 (Q 0) capacitor c=50f m=1
simulatorOptions options temp=27
tran tran stop=30n
