// Design: Design/4BitAdder_unit
simulator lang=spectre
global 0 vdd!
include "/home/ugrads/r/rohitbarichello/cadence/models/spectre/tsmc20N.m"
include "/home/ugrads/r/rohitbarichello/cadence/models/spectre/tsmc20P.m"

// Design/nand2/schematic
subckt nand2 A B GND VDD Y
    P1 (Y A VDD VDD) tsmc20P w=700n l=200n m=1 region=sat
    P0 (Y B VDD VDD) tsmc20P w=700n l=200n m=1 region=sat
    N1 (net18 B GND GND) tsmc20N w=300n l=200n m=1 region=sat
    N0 (Y A net18 GND) tsmc20N w=300n l=200n m=1 region=sat
ends nand2

// Design/inverter/schematic
subckt inverter GND VDD in out
    P0 (out in VDD VDD) tsmc20P w=700n l=200n m=1 region=sat
    N0 (out in GND GND) tsmc20N w=300n l=200n m=1 region=sat
ends inverter

// Design/xor2/schematic
subckt xor2 A B GND VDD Y
    I1 (GND VDD B net26) inverter
    I0 (GND VDD A net12) inverter
    P3 (Y A net29 VDD) tsmc20P w=700n l=200n m=1 region=sat
    P2 (Y net12 net34 VDD) tsmc20P w=700n l=200n m=1 region=sat
    P1 (net29 net26 VDD VDD) tsmc20P w=700n l=200n m=1 region=sat
    P0 (net34 B VDD VDD) tsmc20P w=700n l=200n m=1 region=sat
    N3 (net31 B GND GND) tsmc20N w=300n l=200n m=1 region=sat
    N2 (net35 net26 GND GND) tsmc20N w=300n l=200n m=1 region=sat
    N1 (Y A net31 GND) tsmc20N w=300n l=200n m=1 region=sat
    N0 (Y net12 net35 GND) tsmc20N w=300n l=200n m=1 region=sat
ends xor2

// Design/1BitAdder/schematic
subckt Design_1BitAdder_schematic A B Cin Cout GND S VDD
    I2 (net24 net23 GND VDD Cout) nand2
    I1 (A B GND VDD net23) nand2
    I0 (net16 Cin GND VDD net24) nand2
    I4 (net16 Cin GND VDD S) xor2
    I3 (A B GND VDD net16) xor2
ends Design_1BitAdder_schematic

// Design/4BitAdder/schematic
subckt Design_4BitAdder_schematic A0 A1 A2 A3 B0 B1 B2 B3 Cin Cout GND S0 S1 S2 S3 VDD
    I3 (A1 B1 net32 net33 GND S1 VDD) Design_1BitAdder_schematic
    I2 (A3 B3 net34 Cout GND S3 VDD) Design_1BitAdder_schematic
    I1 (A2 B2 net33 net34 GND S2 VDD) Design_1BitAdder_schematic
    I0 (A0 B0 Cin net32 GND S0 VDD) Design_1BitAdder_schematic
ends Design_4BitAdder_schematic

// Design/4BitAdder_unit/schematic
I0 (A0 A1 A2 A3 B0 B1 B2 B3 Cin Cout 0 S0 S1 S2 S3 vdd!) Design_4BitAdder_schematic
V0 (vdd! 0) vsource type=dc dc=1.8
C4 (Cout 0) capacitor c=50f m=1
C3 (S0 0) capacitor c=50f m=1
C2 (S1 0) capacitor c=50f m=1
C1 (S2 0) capacitor c=50f m=1
C0 (S3 0) capacitor c=50f m=1
V13 (A3 0) vsource type=pulse dc=1.8 val0=0 val1=0 period=12n delay=3n rise=100p fall=100p width=5n
V12 (A2 0) vsource type=pulse dc=1.8 val0=0 val1=1.8 period=12n delay=3n rise=100p fall=100p width=5n
V11 (A1 0) vsource type=pulse dc=1.8 val0=0 val1=0 period=12n delay=3n rise=100p fall=100p width=5n
V10 (A0 0) vsource type=pulse dc=1.8 val0=0 val1=1.8 period=12n delay=3n rise=100p fall=100p width=5n
V9 (Cin 0) vsource type=pulse dc=1.8 val0=0 val1=0 period=12n delay=3n rise=100p fall=100p width=5n
V8 (B3 0) vsource type=pulse dc=1.8 val0=0 val1=1.8 period=12n delay=3n rise=100p fall=100p width=5n
V7 (B2 0) vsource type=pulse dc=1.8 val0=0 val1=0 period=12n delay=3n rise=100p fall=100p width=5n
V6 (B1 0) vsource type=pulse dc=1.8 val0=0 val1=1.8 period=12n delay=3n rise=100p fall=100p width=5n
V5 (B0 0) vsource type=pulse dc=1.8 val0=0 val1=0 period=12n delay=3n rise=100p fall=100p width=5n
simulatorOptions options temp=27
tran tran stop=30n
