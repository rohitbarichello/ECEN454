// Design: Design/xor2_simulate
simulator lang=spectre
global 0 vdd!
include "/home/ugrads/r/rohitbarichello/cadence/models/spectre/tsmc20P.m"
include "/home/ugrads/r/rohitbarichello/cadence/models/spectre/tsmc20N.m"

// Design/inverter/schematic
subckt inverter GND VDD in out
    P0 (out in VDD VDD) tsmc20P w=700n l=200n m=1 region=sat
    N0 (out in GND GND) tsmc20N w=300n l=200n m=1 region=sat
ends inverter

// Design/xor2/schematic
subckt xor2 A B GND VDD Y
    I1 (GND VDD B net26) inverter
    I0 (GND VDD A net12) inverter
    P3 (Y A net29 VDD) tsmc20P w=700n l=200n m=1 region=sat
    P2 (Y net12 net34 VDD) tsmc20P w=700n l=200n m=1 region=sat
    P1 (net29 net26 VDD VDD) tsmc20P w=700n l=200n m=1 region=sat
    P0 (net34 B VDD VDD) tsmc20P w=700n l=200n m=1 region=sat
    N3 (net31 B GND GND) tsmc20N w=300n l=200n m=1 region=sat
    N2 (net35 net26 GND GND) tsmc20N w=300n l=200n m=1 region=sat
    N1 (Y A net31 GND) tsmc20N w=300n l=200n m=1 region=sat
    N0 (Y net12 net35 GND) tsmc20N w=300n l=200n m=1 region=sat
ends xor2

// Design/xor2_simulate/schematic
I0 (A B 0 vdd! out) xor2
V2 (B 0) vsource type=pulse dc=1.8 val0=0 val1=1.8 period=12n delay=3n rise=100p fall=100p width=5n
V0 (A 0) vsource type=pulse dc=1.8 val0=0 val1=1.8 period=12n delay=3n rise=100p fall=100p width=5n
V1 (vdd! 0) vsource type=dc dc=1.8
C0 (out 0) capacitor c=50f m=1
simulatorOptions options temp=27
tran tran stop=30n
